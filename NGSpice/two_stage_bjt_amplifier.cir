* ============================================================
* Two-stage RC-coupled BJT amplifier for low-frequency sensors
* NGSpice project created from scratch
* Supply: 12 V DC
* Transistors: 2N2222A-like NPN model from local bjt_models.lib
* ============================================================

.include ./bjt_models.lib

* ============================================================
* PARAMETERS
* Change VINPK between 10m and 50m to review normal input range.
* Default uses 20 mV peak at 1 kHz.
* ============================================================
.param VCCVAL=12
.param VINPK=20m
.param FIN=1k
.param RSENSOR=1k

* ============================================================
* SUPPLY AND INPUT SOURCE SECTION
* input_signal is the named input node after sensor/source resistance.
* ============================================================
VCC vcc 0 DC {VCCVAL}
VSIG sensor_src 0 SIN(0 {VINPK} {FIN}) AC 1
RSIG sensor_src input_signal {RSENSOR}

* ============================================================
* STAGE 1: COMMON-EMITTER VOLTAGE AMPLIFIER
* Bias target: collector near mid-supply, emitter near 1.1 V.
* R1/R2 provide base bias. RE1A gives AC degeneration.
* RE1B is bypassed to increase midband gain while keeping DC stability.
* ============================================================
CIN input_signal b1 1u
RB1 vcc b1 100k
RB2 b1 0 18k
Q1 c1 b1 e1 Q2N2222A
RC1 vcc c1 4.7k
RE1A e1 e1_low 680
RE1B e1_low 0 560
CE1 e1_low 0 47u

* ============================================================
* INTERSTAGE RC COUPLING
* The coupling capacitor blocks DC from stage 1 and passes AC signal to stage 2.
* ============================================================
C12 c1 b2 1u

* ============================================================
* STAGE 2: COMMON-EMITTER VOLTAGE AMPLIFIER
* Same biasing method as stage 1. Output is taken from collector c2.
* ============================================================
RB3 vcc b2 100k
RB4 b2 0 18k
Q2 c2 b2 e2 Q2N2222A
RC2 vcc c2 4.7k
RE2A e2 e2_low 680
RE2B e2_low 0 560
CE2 e2_low 0 47u

* ============================================================
* OUTPUT COUPLING AND LOAD SECTION
* amplified_output is the named output node after the output coupling capacitor.
* 10 kOhm represents a realistic high-impedance measurement/load input.
* ============================================================
COUT c2 amplified_output 10u
RLOAD amplified_output 0 10k

* ============================================================
* ANALYSES AND MEASUREMENTS
* The control block performs OP, transient, and AC sweep in one run.
* Outputs are written as local files for engineering review.
* ============================================================
.control
set noaskquit
destroy all

echo ===== CLEAN CONTROL BLOCK V2 =====

echo ===== DC OPERATING POINT ANALYSIS =====
op
print v(vcc) v(b1) v(e1) v(c1) v(b2) v(e2) v(c2)
let vce1 = v(c1)-v(e1)
let vce2 = v(c2)-v(e2)
print vce1 vce2

echo ===== TRANSIENT ANALYSIS =====
tran 5u 30m

plot v(input_signal) v(amplified_output)

meas tran vin_max  MAX v(input_signal)      FROM=20m TO=30m
meas tran vin_min  MIN v(input_signal)      FROM=20m TO=30m
meas tran vout_max MAX v(amplified_output)  FROM=20m TO=30m
meas tran vout_min MIN v(amplified_output)  FROM=20m TO=30m

let vin_pp = vin_max - vin_min
let vout_pp = vout_max - vout_min
let tran_gain_calc = vout_pp / vin_pp
print vin_pp vout_pp tran_gain_calc

wrdata transient_waveforms.csv time v(input_signal) v(c1) v(amplified_output)

echo ===== AC SWEEP ANALYSIS =====
ac dec 100 10 100k

let gain_total_calc = v(amplified_output)/v(input_signal)
let gain_db_calc = db(gain_total_calc)

plot gain_db_calc

meas ac gain_10hz  FIND gain_db_calc AT=10
meas ac gain_1khz  FIND gain_db_calc AT=1k
meas ac gain_20khz FIND gain_db_calc AT=20k

wrdata ac_response.csv frequency gain_total_calc gain_db_calc

write two_stage_bjt_amplifier.raw
.endc

.end
