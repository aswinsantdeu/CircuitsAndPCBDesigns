ADDER - 2 BIT ALL-NAND-GATE BINARY ADDER

* use BSIM3 model with default parameters
.model n1 nmos level=49 version=3.3.0
.model p1 pmos level=49 version=3.3.0

*** SUBCIRCUIT DEFINITIONS
.SUBCKT NAND in1 in2 out VDD
* NODES: INPUT(2), OUTPUT, VDD
M1 out in2 VDD VDD p1 W=7.5u L=0.35u pd=13.5u ad=22.5p ps=13.5u as=22.5p
M2 net.1 in2 0 0 n1 W=3u L=0.35u pd=9u ad=9p ps=9u as=9p
M3 out in1 VDD VDD p1 W=7.5u L=0.35u pd=13.5u ad=22.5p ps=13.5u as=22.5p
M4 out in1 net.1 0 n1 W=3u L=0.35u pd=9u ad=9p ps=9u as=9p
.ENDS NAND

.SUBCKT ONEBIT 1 2 3 4 5 6
* 1=A, 2=B, 3=Cin, 4=Sum, 5=Cout, 6=VDD
X1 1 2 7 6 NAND
X2 1 7 8 6 NAND
X3 2 7 9 6 NAND
X4 8 9 10 6 NAND
X5 3 10 11 6 NAND
X6 3 11 12 6 NAND
X7 10 11 13 6 NAND
X8 12 13 4 6 NAND
X9 11 7 5 6 NAND
.ENDS ONEBIT

.SUBCKT TWOBIT 1 2 3 4 5 6 7 8 9
* 1=A0, 2=B0, 3=A1, 4=B1, 5=S0, 6=S1, 7=Cin, 8=Cout, 9=VDD
X1 1 2 7 5 10 9 ONEBIT
X2 3 4 10 6 8 9 ONEBIT
.ENDS TWOBIT

*** POWER
VCC 99 0 DC 3.3

*** INPUTS
* A0, B0, A1, B1
VIN1A 1 0 DC 0 PULSE(0 3.3 0 5NS 5NS 20NS 50NS)
VIN1B 2 0 DC 0 PULSE(0 3.3 0 5NS 5NS 30NS 100NS)
VIN2A 3 0 DC 0 PULSE(0 3.3 0 5NS 5NS 50NS 200NS)
VIN2B 4 0 DC 0 PULSE(0 3.3 0 5NS 5NS 90NS 400NS)

*** TOP LEVEL 2-BIT ADDER
* Nodes: A0 B0 A1 B1 S0 S1 Cin Cout VDD
X1 1 2 3 4 5 6 0 7 99 TWOBIT

.option acct
.save V(1) V(2) V(3) V(4)
.save V(5) V(6) V(7)

.tran 1NS 400NS

.control
run
plot v(1) v(2)+4 v(3)+8 v(4)+12
plot v(5) v(6)+4 v(7)+8
.endc

.end
