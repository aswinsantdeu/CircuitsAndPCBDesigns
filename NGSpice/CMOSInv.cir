* CMOS inverter with transient and delay measurement

* 5 V supply
Vdd vdd 0 5

* Pulse input: 0 to 5 V
Vin in 0 PULSE(0 5 0 1n 1n 50n 100n)

* NMOS: drain gate source bulk model
M1 out in 0 0 NMOS1

* PMOS: drain gate source bulk model
M2 out in vdd vdd PMOS1

* NMOS model
.model NMOS1 NMOS (LEVEL=1 VTO=1 KP=100u LAMBDA=0.02)

* PMOS model
.model PMOS1 PMOS (LEVEL=1 VTO=-1 KP=100u LAMBDA=0.02)

* Output load capacitance
Cload out 0 10p

.control

echo "================ OPERATING POINT ================"
op
print v(in) v(out)
print @m1[id] @m1[vgs] @m1[vds]
print @m2[id] @m2[vgs] @m2[vds]

echo "================ TRANSIENT ======================"
* Simulate time-domain response
tran 0.1n 300n

* Plot input and output
plot v(in) v(out)

echo "================ Propagation delays ======================"
* Measure propagation delays
meas tran tphl TRIG v(in) VAL=2.5 RISE=1 TARG v(out) VAL=2.5 FALL=1
meas tran tplh TRIG v(in) VAL=2.5 FALL=1 TARG v(out) VAL=2.5 RISE=1

echo "================ Voltage Swing ======================"
* Measure voltage swing
meas tran VOH MAX v(out) VAL=4.5
meas tran VOL MIN v(out) VAL=0.5

echo "================ Rise and Fall Time ======================"
meas tran trise TRIG v(in) VAL=2.5 RISE=1 TARG v(out) VAL=2.5 RISE=1
meas tran tfall TRIG v(in) VAL=2.5 FALL=1 TARG v(out) VAL=2.5 FALL=1

.endc
.end
